** Profile: "SCHEMATIC1-Loss"  [ C:\Users\ahmet\Desktop\LossSimulation\powerloss-pspicefiles\schematic1\loss.sim ]

** Creating circuit file "Loss.cir"
** WARNING: THIS AUTOMATICALLY GENERATED FILE MAY BE OVERWRITTEN BY SUBSEQUENT SIMULATIONS

*Libraries:
* Profile Libraries :
* Local Libraries :
.LIB "C:/Users/ahmet/Desktop/mv5_100v_std_rev1p0_pspice.txt"
* From [PSPICE NETLIST] section of C:\Users\ahmet\AppData\Roaming\SPB_Data\cdssetup\OrCAD_PSpice\17.4.0\PSpice.ini file:
.lib "nom.lib"

*Analysis directives:
.DC LIN TEMP 0 100 1
.OPTIONS ADVCONV
.OPTIONS ABSTOL= 1.0u
.PROBE64 V(alias(*)) I(alias(*)) W(alias(*)) D(alias(*)) NOISE(alias(*))
.INC "..\SCHEMATIC1.net"

.END
