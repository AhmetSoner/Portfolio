** Profile: "SCHEMATIC1-manasininnani"  [ C:\Users\ahmet\Desktop\gatedenyiyenler\Gatedenyemisler-PSpiceFiles\SCHEMATIC1\manasininnani.sim ]

** Creating circuit file "manasininnani.cir"
** WARNING: THIS AUTOMATICALLY GENERATED FILE MAY BE OVERWRITTEN BY SUBSEQUENT SIMULATIONS

*Libraries:
* Profile Libraries :
* Local Libraries :
.LIB "C:/Users/ahmet/Desktop/bipolar.lib.txt"
.LIB "C:/Users/ahmet/Desktop/mosfet spice model/optimos5/optimos5_100v_cadence_pspice.lib"
.LIB "C:/Users/ahmet/Desktop/pspice/kapasitor/wcap-atg8.lib"
.LIB "C:/Users/ahmet/Desktop/pspice/kapasitor/wcap-aig8.lib"
.LIB "C:/Users/ahmet/Desktop/pspice/kapasitor/wcap-at1h.lib"
.LIB "C:/Users/ahmet/Desktop/pspice/kapasitor/we-csgp_simple_models/wcap-csgp_100v.lib"
.LIB "C:/Users/ahmet/Desktop/pspice/kapasitor/we-csgp_simple_models/wcap-csgp_50v.lib"
.LIB "C:/Users/ahmet/Desktop/pspice/kapasitor/we-csgp_simple_models/wcap-csgp_25v.lib"
.LIB "C:/Users/ahmet/Desktop/pspice/ucc21550-q1.lib"
* From [PSPICE NETLIST] section of C:\Users\ahmet\AppData\Roaming\SPB_Data\cdssetup\OrCAD_PSpice\22.1.0\PSpice.ini file:
.lib "nom.lib"

*Analysis directives:
.TRAN  0 200us 0
.OPTIONS ADVCONV
.PROBE64 V(alias(*)) I(alias(*)) W(alias(*)) D(alias(*)) NOISE(alias(*))
.INC "..\SCHEMATIC1.net"

.END
