** Profile: "SCHEMATIC1-matlab"  [ C:\Users\ahmet\Desktop\Boards\Motor Surucu Hesaplama\Simulasyon\gatedenyiyenler\gatedenyemisler-pspicefiles\schematic1\matlab.sim ]

** Creating circuit file "matlab.cir"
** WARNING: THIS AUTOMATICALLY GENERATED FILE MAY BE OVERWRITTEN BY SUBSEQUENT SIMULATIONS

*Libraries:
* Profile Libraries :
* Local Libraries :
.LIB "C:/Users/ahmet/Desktop/PSPice Lib/TMCS1126x1A.lib"
.LIB "C:/Users/ahmet/Desktop/PSPice Lib/ina226.lib"
.LIB "C:/Users/ahmet/Desktop/PSPice Lib/MV5_100V_STD_rev1p0_pspice.txt"
.LIB "C:/Users/ahmet/Desktop/PSPice Lib/UCC/ucc21550-q1.lib"
.LIB "C:/Users/ahmet/Desktop/PSPice Lib/WCAP-AIG5.lib"
.LIB "C:/Users/ahmet/Desktop/PSPice Lib/B0530W.spice.txt"
.LIB "C:/Users/ahmet/Desktop/PSPice Lib/WE-CSGP_Simple_Models/WCAP-CSGP_6-3V.lib"
.LIB "C:/Users/ahmet/Desktop/PSPice Lib/WE-CSGP_Simple_Models/WCAP-CSGP_10V.lib"
.LIB "C:/Users/ahmet/Desktop/PSPice Lib/WE-CSGP_Simple_Models/WCAP-CSGP_25V.lib"
.LIB "C:/Users/ahmet/Desktop/PSPice Lib/WE-CSGP_Simple_Models/WCAP-CSGP_50V.lib"
.LIB "C:/Users/ahmet/Desktop/PSPice Lib/WE-CSGP_Simple_Models/WCAP-CSGP_100V.lib"
.LIB "C:/Users/ahmet/Desktop/PSPice Lib/WCAP-ATG5.lib"
.LIB "C:/Users/ahmet/Desktop/PSPice Lib/WCAP-FTDB.lib"
* From [PSPICE NETLIST] section of C:\Users\ahmet\AppData\Roaming\SPB_Data\cdssetup\OrCAD_PSpice\22.1.0\PSpice.ini file:
.lib "nom.lib"

*Analysis directives:
.OPTIONS STEPGMIN
.OPTIONS ADVCONV
.AUTOCONVERGE ITL1=1000 ITL2=1000 ITL4=1000 RELTOL=0.05 ABSTOL=1.0E-6 VNTOL=.001 PIVTOL=1.0E-10
.PROBE64 V(alias(*)) I(alias(*)) W(alias(*)) D(alias(*)) NOISE(alias(*))

.subckt PSpiceBlock dummy
* source GATEDENYEMISLER
* PSpice Text Block on SCHEMATIC1 ALLAHCANIMIALSADAKURTULSAM
.OPTIONS PTRANABSTOL=1E-5 PTRANVNTOL=1E-4
***
* PSpice Text Block on SCHEMATIC1 NECMÝ THE SAW
.OPTIONS PTRANABSTOL=1E-5 PTRANVNTOL=1E-4
***
X_U4         N15264 N15268 N14625 N14694 0 N14908 N15321 N16059 N15373 N15832
+  N17380 0 UCC21550-Q1
X_C63         N14694 N14625 CSGP_0805_885012207072_100nF
X_C62         N14694 N14625 CSGP_0805_885012207078_1uF
V_V22         N14625 N14694 5
X_C68         N14908 0 CSGP_0805_885012207072_100nF
R_R63         N14908 0  20k TC=0,0
V_V19         N1003523 0 12
R_R52         N150811 N1003523  2 TC=0,0
X_C58         N15373 N15321 CSGP_0805_885012207072_100nF
X_D23         N16097 N16105 power_diode_p PARAMS: I_REV_LEAK=0.5m
+  CT_ZERO_VOLTS=50p V_BR=40 VJ_KNEE=0.55 VJ_SPEC=0.85 IF_SPEC=1
R_R54         N16646 N16105  109 TC=0,0
R_R53         N16646 N16097  76.5 TC=0,0
R_R59         N16646 N15373  10k TC=0,0
R_R55         N162571 N16646  3 TC=0,0
R_R58         N167891 N16646  3 TC=0,0
R_R61         N17360 N17356  76.5 TC=0,0
X_D24         N17356 N17348 power_diode_p PARAMS: I_REV_LEAK=0.5m
+  CT_ZERO_VOLTS=50p V_BR=40 VJ_KNEE=0.55 VJ_SPEC=0.85 IF_SPEC=1
R_R65         N17360 N17348  109 TC=0,0
R_R68         N17360 0  10k TC=0,0
R_R67         N988736 N17360  3 TC=0,0
R_R66         N176081 N17360  3 TC=0,0
X_C69         0 N15832 CSGP_1206_885012208089_220nF
R_R78         N22338 0  20k TC=0,0
R_R74         N1020785 N21488  3 TC=0,0
R_R84         N22322 N22308  109 TC=0,0
R_R80         N22322 N22316  76.5 TC=0,0
X_D30         N21482 N21474 power_diode_p PARAMS: I_REV_LEAK=0.5m
+  CT_ZERO_VOLTS=50p V_BR=40 VJ_KNEE=0.55 VJ_SPEC=0.85 IF_SPEC=1
R_R77         N21488 N21838  10k TC=0,0
V_V28         N1004356 0 12
R_R71         N21488 N21482  76.5 TC=0,0
X_D31         N22316 N22308 power_diode_p PARAMS: I_REV_LEAK=0.5m
+  CT_ZERO_VOLTS=50p V_BR=40 VJ_KNEE=0.55 VJ_SPEC=0.85 IF_SPEC=1
X_C90         0 N22334 CSGP_1206_885012208089_220nF
V_V31         N21726 N22222 5
R_R75         N1022141 N21488  3 TC=0,0
R_R73         N21488 N21474  109 TC=0,0
X_C80         N22222 N21726 CSGP_0805_885012207072_100nF
R_R86         N22322 0  10k TC=0,0
X_U6         N709478 N22562 N21726 N22222 0 N22338 N21394 N21930 N21838 N22334
+  N22568 0 UCC21550-Q1
R_R85         N1022139 N22322  3 TC=0,0
R_R69         N213601 N1004356  2 TC=0,0
X_C75         N21838 N21394 CSGP_0805_885012207072_100nF
X_C85         N22338 0 CSGP_0805_885012207072_100nF
R_R83         N1022143 N22322  3 TC=0,0
X_C79         N22222 N21726 CSGP_0805_885012207078_1uF
R_R92         N248981 N24508  3 TC=0,0
X_C106         N25358 0 CSGP_0805_885012207072_100nF
V_V36         N1004853 0 12
X_C100         N25242 N24746 CSGP_0805_885012207078_1uF
X_U7         N24996 N25582 N24746 N25242 0 N25358 N24414 N24950 N24858 N25354
+  N25588 0 UCC21550-Q1
R_R91         N24508 N24494  109 TC=0,0
X_D37         N24502 N24494 power_diode_p PARAMS: I_REV_LEAK=0.5m
+  CT_ZERO_VOLTS=50p V_BR=40 VJ_KNEE=0.55 VJ_SPEC=0.85 IF_SPEC=1
X_C101         N25242 N24746 CSGP_0805_885012207072_100nF
R_R94         N24508 N24858  10k TC=0,0
R_R93         N249181 N24508  3 TC=0,0
X_C109         0 N25354 CSGP_1206_885012208089_220nF
R_R97         N25342 N25336  76.5 TC=0,0
R_R87         N243801 N1004853  2 TC=0,0
V_V39         N24746 N25242 5
R_R96         N25358 0  20k TC=0,0
R_R102         N25342 N25328  109 TC=0,0
R_R101         N1043959 N25342  3 TC=0,0
X_D38         N25336 N25328 power_diode_p PARAMS: I_REV_LEAK=0.5m
+  CT_ZERO_VOLTS=50p V_BR=40 VJ_KNEE=0.55 VJ_SPEC=0.85 IF_SPEC=1
R_R100         N255301 N25342  3 TC=0,0
R_R103         N25342 0  10k TC=0,0
X_C96         N24858 N24414 CSGP_0805_885012207072_100nF
R_R88         N24508 N24502  76.5 TC=0,0
V_V24         N17127 0 48
V_V32         N21650 0 48
V_V41         N24670 0 48
R_R70         N709478 N709472  1 TC=0,0
X_U5         N21976 N709478 Sw_tOpen PARAMS: tOpen=35u ttran=1u Rclosed=0.01
+  Ropen=1Meg
X_V27         N709472 0 VPULSEN PARAMS: V1=0 V2=3.3 TD=100u TR=100n TF=100n
+  PW=39.5u PER=120u NVAL=0.05
X_V30         N21976 0 VPULSEN PARAMS: V1=0 V2=3.3 TD=0 TR=100n TF=100n
+  PW=19.5u PER=50 NVAL=0.05
X_V34         N22562 0 VPULSEN PARAMS: V1=0 V2=3.3 TD=40u TR=100n TF=100n
+  PW=39.5u PER=120u NVAL=0.05
X_C108         N25354 0 CSGP_1206_885012108022_10uF
X_C91         N22334 0 CSGP_1206_885012108022_10uF
X_C70         N15832 0 CSGP_1206_885012108022_10uF
X_D29         N213601 N21394 power_diode_p PARAMS: I_REV_LEAK=10u
+  CT_ZERO_VOLTS=167p V_BR=1200 VJ_KNEE=1.4 VJ_SPEC=1.9 IF_SPEC=10
X_D22         N150811 N15321 power_diode_p PARAMS: I_REV_LEAK=10u
+  CT_ZERO_VOLTS=167p V_BR=1200 VJ_KNEE=1.4 VJ_SPEC=1.9 IF_SPEC=13
X_D36         N243801 N24414 power_diode_p PARAMS: I_REV_LEAK=10u
+  CT_ZERO_VOLTS=167p V_BR=1200 VJ_KNEE=1.4 VJ_SPEC=1.9 IF_SPEC=13
X_M19         N15373 N21838 N24858 M_UN0001 M_UN0002 BLDCMTR_WYE
+ PARAMS: J=1410_g*cm*sec*sec B=1084_g*cm*sec/rad F=3580_g*cm D=11675_g*cm
+  A=26 Cl=0.000000543954H Cr=0.0201498 Cc=35.5uF Cm=0.0000002175816
+  Cb=0.935262_Volt*sec/rev Ct=9714_g*cm/amp
X_V42         N25582 0 VPULSEN PARAMS: V1=0 V2=3.3 TD=80u TR=100n TF=100n
+  PW=39.5u PER=120u NVAL=0.01
X_V25         N15268 0 VPULSEN PARAMS: V1=0 V2=3.3 TD=0 TR=100n TF=100n
+  PW=39.5u PER=120u NVAL=0.01
X_V38         N24996 0 VPULSEN PARAMS: V1=0 V2=3.3 TD=20u TR=100n TF=100n
+  PW=39.5u PER=120u NVAL=0.01
X_V21         N15264 0 VPULSEN PARAMS: V1=0 V2=3.3 TD=60u TR=100n TF=100n
+  PW=39.5u PER=120u NVAL=0.01
X_M13         N17127 N162571 N15373 power_nmos_p PARAMS: BVDSS=100 IDSS=1u
+  VGS_TH=2.7 RDSON=2.6m GFS=59 CISS=6101p COSS=1343p CRSS=46p RG=2.7 VSD=0.85
+  QG=84n V_QG=10 TRR=103n
C_C64         0 N17127  4.7u  TC=0,0
C_C81         0 N21650  4.7u  TC=0,0
X_C59         N15373 N15321 CSGP_2220_885012214006_10uF
X_C76         N21838 N21394 CSGP_2220_885012214006_10uF
X_C97         N24858 N24414 CSGP_2220_885012214006_10uF
X_C57         0 N1003523 CSGP_0805_885012207098_100nF
X_C56         N1003523 0 CSGP_0805_885012207103_1uF
X_C73         N1004356 0 CSGP_0805_885012207103_1uF
X_C74         0 N1004356 CSGP_0805_885012207098_100nF
X_C95         0 N1004853 CSGP_0805_885012207098_100nF
X_C94         N1004853 0 CSGP_0805_885012207103_1uF
X_M16         N15373 N176081 0 power_nmos_p PARAMS: BVDSS=100 IDSS=1u
+  VGS_TH=2.7 RDSON=2.6m GFS=59 CISS=6101p COSS=1343p CRSS=46p RG=2.7 VSD=0.85
+  QG=84n V_QG=20 TRR=103n
X_M15         N15373 N988736 0 power_nmos_p PARAMS: BVDSS=100 IDSS=1u
+  VGS_TH=2.7 RDSON=2.6m GFS=59 CISS=6101p COSS=1343p CRSS=46p RG=2.7 VSD=0.85
+  QG=84n V_QG=20 TRR=103n
X_M14         N17127 N167891 N15373 power_nmos_p PARAMS: BVDSS=100 IDSS=1u
+  VGS_TH=2.7 RDSON=2.6m GFS=59 CISS=6101p COSS=1343p CRSS=46p RG=2.7 VSD=0.85
+  QG=84n V_QG=20 TRR=103n
X_M20         N21838 N1022143 0 power_nmos_p PARAMS: BVDSS=100 IDSS=1u
+  VGS_TH=2.7 RDSON=2.6m GFS=59 CISS=6101p COSS=1343p CRSS=46p RG=2.7 VSD=0.85
+  QG=84n V_QG=20 TRR=103n
X_M21         N21838 N1022139 0 power_nmos_p PARAMS: BVDSS=100 IDSS=1u
+  VGS_TH=2.7 RDSON=2.6m GFS=59 CISS=6101p COSS=1343p CRSS=46p RG=2.7 VSD=0.85
+  QG=84n V_QG=20 TRR=103n
X_M17         N21650 N1020785 N21838 power_nmos_p PARAMS: BVDSS=100 IDSS=1u
+  VGS_TH=2.7 RDSON=2.6m GFS=59 CISS=6101p COSS=1343p CRSS=46p RG=2.7 VSD=0.85
+  QG=84n V_QG=20 TRR=103n
X_M18         N21650 N1022141 N21838 power_nmos_p PARAMS: BVDSS=100 IDSS=1u
+  VGS_TH=2.7 RDSON=2.6m GFS=59 CISS=6101p COSS=1343p CRSS=46p RG=2.7 VSD=0.85
+  QG=84n V_QG=20 TRR=103n
X_M23         N24670 N249181 N24858 power_nmos_p PARAMS: BVDSS=100 IDSS=1u
+  VGS_TH=2.7 RDSON=2.6m GFS=59 CISS=6101p COSS=1343p CRSS=46p RG=2.7 VSD=0.85
+  QG=84n V_QG=20 TRR=103n
X_M22         N24670 N248981 N24858 power_nmos_p PARAMS: BVDSS=100 IDSS=1u
+  VGS_TH=2.7 RDSON=2.6m GFS=59 CISS=6101p COSS=1343p CRSS=46p RG=2.7 VSD=0.85
+  QG=84n V_QG=20 TRR=103n
X_M25         N24858 N255301 0 power_nmos_p PARAMS: BVDSS=100 IDSS=1u
+  VGS_TH=2.7 RDSON=2.6m GFS=59 CISS=6101p COSS=1343p CRSS=46p RG=2.7 VSD=0.85
+  QG=84n V_QG=20 TRR=103n
X_M24         N24858 N1043959 0 power_nmos_p PARAMS: BVDSS=100 IDSS=1u
+  VGS_TH=2.7 RDSON=2.6m GFS=59 CISS=6101p COSS=1343p CRSS=46p RG=2.7 VSD=0.85
+  QG=84n V_QG=20 TRR=103n
D_D25         N15373 N16646 DI_B0530W
D_D26         N15373 N16646 DI_B0530W
D_D27         0 N17360 DI_B0530W
D_D28         0 N17360 DI_B0530W
D_D32         N21838 N21488 DI_B0530W
D_D33         N21838 N21488 DI_B0530W
D_D35         0 N22322 DI_B0530W
D_D34         0 N22322 DI_B0530W
D_D40         N24858 N24508 DI_B0530W
D_D39         N24858 N24508 DI_B0530W
D_D42         0 N25342 DI_B0530W
D_D41         0 N25342 DI_B0530W
C_C65         0 N17127  4.7u  TC=0,0
C_C102         0 N24670  4.7u  TC=0,0
C_C67         0 N17127  4.7u  TC=0,0
C_C66         0 N17127  4.7u  TC=0,0
C_C84         0 N21650  4.7u  TC=0,0
C_C82         0 N21650  4.7u  TC=0,0
C_C83         0 N21650  4.7u  TC=0,0
C_C103         0 N24670  4.7u  TC=0,0
C_C105         0 N24670  4.7u  TC=0,0
C_C104         0 N24670  4.7u  TC=0,0
V_V29         N21394 N21838 12
V_V37         N24414 N24858 12
V_V20         N15321 N15373 12
X_C89         0 N17127 FTDB_890764427009CS_10uF
X_C86         0 N17127 AIG5_861021386031_0R47mF
X_C87         0 N17127 AIG5_861021386031_0R47mF
X_C88         0 N17127 AIG5_861021386031_0R47mF
V_V43         N25354 0 12
V_V35         N22334 0 12
V_V26         N15832 0 12
V_V40         N25350 0 12
V_V33         N22330 0 12
V_V23         N15960 0 12
L_L7         N16059 N16105  0.00967u
L_L9         N21930 N21474  0.00967u
L_L11         N24950 N24494  0.00967u
L_L8         N17380 N17348  0.06465u
L_L10         N22568 N22308  0.06465u
L_L12         N25588 N25328  0.06465u
R_R79         N22330 N22334  1 TC=0,0
R_R95         N25350 N25354  1 TC=0,0
R_R60         N15960 N15832  1 TC=0,0
R_R56         N17127 N11798330  20 TC=0,0
X_C60         N15373 N11798330 CSGP_2220_885012214006_10uF
R_R57         N17127 N11800100  20 TC=0,0
X_C61         N15373 N11800100 CSGP_2220_885012214006_10uF
R_R62         N15373 N11801740  20 TC=0,0
X_C71         0 N11801740 CSGP_2220_885012214006_10uF
X_C72         0 N11804850 CSGP_2220_885012214006_10uF
R_R64         N15373 N11804850  20 TC=0,0
X_C78         N21838 N11814080 CSGP_2220_885012214006_10uF
R_R76         N21650 N11814080  20 TC=0,0
X_C93         0 N11815620 CSGP_2220_885012214006_10uF
R_R82         N21838 N11815620  20 TC=0,0
X_C92         0 N1182484 CSGP_2220_885012214006_10uF
R_R81         N21838 N1182484  20 TC=0,0
X_C99         N24858 N1182660 CSGP_2220_885012214006_10uF
R_R90         N24670 N1182660  20 TC=0,0
R_R89         N24670 N1182865  20 TC=0,0
X_C98         N24858 N1182865 CSGP_2220_885012214006_10uF
R_R99         N24858 N11831780  20 TC=0,0
X_C110         0 N11831780 CSGP_2220_885012214006_10uF
R_R98         N24858 N11834870  20 TC=0,0
X_C107         0 N11834870 CSGP_2220_885012214006_10uF
X_C77         N21838 N1184383 CSGP_2220_885012214006_10uF
R_R72         N21650 N1184383  20 TC=0,0
C_C50         0 N1219436  {Cmos_drain}  TC=0,0
X_M6         N1216954 N1217394 N1217102 power_nmos_p PARAMS: BVDSS=100 IDSS=1u
+  VGS_TH=2.7 RDSON=2.6m GFS=59 CISS=6101p COSS=1343p CRSS=46p RG=2.7 VSD=0.85
+  QG=84n V_QG=20 TRR=103n
X_C46         N1220404 N1219600 CSGP_0805_885012207072_100nF
X_M2         N1214562 N12148061 N1214744 power_nmos_p PARAMS: BVDSS=100 IDSS=1u
+  VGS_TH=2.7 RDSON=2.6m GFS=59 CISS=6101p COSS=1343p CRSS=46p RG=2.7 VSD=0.85
+  QG=84n V_QG=20 TRR=103n
R_R24         N1216954 N12171880  {R_snubber} TC=0,0
R_R26         N1218300 0  {Rdt} TC=0,0
D_D13         0 N1218100 DI_B0530W
X_U1         N1222748 N1222760 N1214664 N1215606 0 N1215750 N1214208 N1214976
+  N1214744 N1215414 N1216014 0 UCC21550-Q1
X_M9         N1219436 N12196641 N1219552 power_nmos_p PARAMS: BVDSS=100 IDSS=1u
+  VGS_TH=2.7 RDSON=2.6m GFS=59 CISS=6101p COSS=1343p CRSS=46p RG=2.7 VSD=0.85
+  QG=84n V_QG=20 TRR=103n
R_R7         N12148061 N1214528  {Rmos_ext} TC=0,0
V_V18         N1220212 0 {Vdriver_out}
X_C15         0 N1215414 CSGP_1206_885012208089_220nF
R_R44         N1220584 0  {Rdt} TC=0,0
V_V11         N1218066 0 {Vdriver_out}
X_D16         N1219288 N1219280 power_diode_p PARAMS: I_REV_LEAK=0.5m
+  CT_ZERO_VOLTS=50p V_BR=40 VJ_KNEE=0.55 VJ_SPEC=0.85 IF_SPEC=1
X_M4         N1214744 N1216140 0 power_nmos_p PARAMS: BVDSS=100 IDSS=1u
+  VGS_TH=2.7 RDSON=2.6m GFS=59 CISS=6101p COSS=1343p CRSS=46p RG=2.7 VSD=0.85
+  QG=84n V_QG=20 TRR=103n
V_V15         N1219600 N1220404 {Vdriver_in}
X_C32         0 N1214562 AIG5_861021386031_0R47mF
X_C2         0 N1214186 CSGP_0805_885012207098_100nF
R_R21         N1217408 N1216916  {Rmos_ext} TC=0,0
D_D6         0 N1215662 DI_B0530W
R_R49         N1220476 N1220462  {Rmos_on} TC=0,0
X_C33         0 N1214562 AIG5_861021386031_0R47mF
X_M8         N1217102 N1218722 0 power_nmos_p PARAMS: BVDSS=100 IDSS=1u
+  VGS_TH=2.7 RDSON=2.6m GFS=59 CISS=6101p COSS=1343p CRSS=46p RG=2.7 VSD=0.85
+  QG=84n V_QG=20 TRR=103n
D_D20         0 N1220476 DI_B0530W
V_V12         N1218074 0 {Vdriver_out}
R_R1         N12141501 N1214186  {Rbootstrap} TC=0,0
R_R23         N1217394 N1216916  {Rmos_ext} TC=0,0
V_V2         N1214208 N1214744 {Vdriver_out}
R_R19         N1216916 N1216910  {Rmos_off} TC=0,0
X_D1         N12141501 N1214208 power_diode_p PARAMS: I_REV_LEAK=10u
+  CT_ZERO_VOLTS=167p V_BR=1200 VJ_KNEE=1.4 VJ_SPEC=1.9 IF_SPEC=13
L_L6         N1220960 N1220462  0.06465u
D_D18         N1219552 N1219294 DI_B0530W
D_D21         0 N1220476 DI_B0530W
X_C3         N1214744 N1214208 CSGP_0805_885012207072_100nF
R_R14         N12158361 N1215662  {Rmos_ext} TC=0,0
R_R13         N1214744 N12156960  {R_snubber} TC=0,0
R_R43         N1220204 N1220212  1 TC=0,0
L_L5         N1219874 N1219280  0.00967u
D_D11         N1217102 N1216916 DI_B0530W
X_C47         N1220584 0 CSGP_0805_885012207072_100nF
R_R38         N1219294 N1219280  {Rmos_on} TC=0,0
V_V10         N1216954 0 {V_bus}
X_C54         0 N1220212 CSGP_1206_885012208089_220nF
X_C25         N1217102 N1217438 CSGP_2220_885012214006_10uF
R_R25         N1216916 N1217102  {Rmos_pulldown} TC=0,0
V_V1         N1214186 0 {Vdriver_out}
R_R40         N1219436 N1219812  {R_snubber} TC=0,0
X_C44         N1219552 N1219680 CSGP_2220_885012214006_10uF
R_R4         N12147581 N1214528  {Rmos_ext} TC=0,0
L_L1         N1214976 N1214514  0.00967u
X_D10         N1218094 N1218086 power_diode_p PARAMS: I_REV_LEAK=0.5m
+  CT_ZERO_VOLTS=50p V_BR=40 VJ_KNEE=0.55 VJ_SPEC=0.85 IF_SPEC=1
X_D8         N12165321 N1216620 power_diode_p PARAMS: I_REV_LEAK=10u
+  CT_ZERO_VOLTS=167p V_BR=1200 VJ_KNEE=1.4 VJ_SPEC=1.9 IF_SPEC=10
X_C16         0 N12156740 CSGP_2220_885012214006_10uF
R_R32         N1218100 N1218086  {Rmos_on} TC=0,0
C_C30         0 N1216954  {Cmos_drain}  TC=0,0
D_D14         0 N1218100 DI_B0530W
X_C40         0 N1219032 CSGP_0805_885012207098_100nF
X_C8         N1215606 N1214664 CSGP_0805_885012207072_100nF
X_C55         0 N12205340 CSGP_2220_885012214006_10uF
X_C11         N1215750 0 CSGP_0805_885012207072_100nF
X_C37         N1218074 0 CSGP_1206_885012108022_10uF
V_V17         N1219436 0 {V_bus}
V_V5         N1215410 0 {Vdriver_out}
X_C23         N1218014 N1217022 CSGP_0805_885012207078_1uF
R_R20         N1216954 N1217438  {R_snubber} TC=0,0
L_L4         N1218590 N1218086  0.06465u
R_R45         N1220476 N1220470  {Rmos_off} TC=0,0
X_M3         N1214744 N12158361 0 power_nmos_p PARAMS: BVDSS=100 IDSS=1u
+  VGS_TH=2.7 RDSON=2.6m GFS=59 CISS=6101p COSS=1343p CRSS=46p RG=2.7 VSD=0.85
+  QG=84n V_QG=20 TRR=103n
C_C9         0 N1214562  {Cmos_drain}  TC=0,0
X_C39         N1219032 0 CSGP_0805_885012207103_1uF
V_V16         N1220204 0 {Vdriver_out}
X_C5         N1214744 N12147820 CSGP_2220_885012214006_10uF
R_R6         N1214528 N1214514  {Rmos_on} TC=0,0
X_C27         N1218300 0 CSGP_0805_885012207072_100nF
X_D9         N1216910 N1216902 power_diode_p PARAMS: I_REV_LEAK=0.5m
+  CT_ZERO_VOLTS=50p V_BR=40 VJ_KNEE=0.55 VJ_SPEC=0.85 IF_SPEC=1
X_C53         0 N12205000 CSGP_2220_885012214006_10uF
X_C52         N1220212 0 CSGP_1206_885012108022_10uF
R_R39         N12196941 N1219294  {Rmos_ext} TC=0,0
X_C24         N1218014 N1217022 CSGP_0805_885012207072_100nF
X_C1         N1214186 0 CSGP_0805_885012207103_1uF
X_D17         N1220470 N1220462 power_diode_p PARAMS: I_REV_LEAK=0.5m
+  CT_ZERO_VOLTS=50p V_BR=40 VJ_KNEE=0.55 VJ_SPEC=0.85 IF_SPEC=1
X_C18         N1216506 0 CSGP_0805_885012207103_1uF
R_R27         N1218066 N1218074  1 TC=0,0
X_D15         N12190581 N1219146 power_diode_p PARAMS: I_REV_LEAK=10u
+  CT_ZERO_VOLTS=167p V_BR=1200 VJ_KNEE=1.4 VJ_SPEC=1.9 IF_SPEC=13
R_R17         N1215662 0  {Rmos_pulldown} TC=0,0
R_R42         N1219294 N1219552  {Rmos_pulldown} TC=0,0
D_D7         0 N1215662 DI_B0530W
X_C4         N1214744 N1214208 CSGP_2220_885012214006_10uF
R_R34         N1218100 0  {Rmos_pulldown} TC=0,0
R_R15         N1215662 N1215648  {Rmos_on} TC=0,0
X_C43         N1219552 N1219812 CSGP_2220_885012214006_10uF
X_C38         0 N12181340 CSGP_2220_885012214006_10uF
C_C12         0 N1214562  {Cmos_drain}  TC=0,0
D_D12         N1217102 N1216916 DI_B0530W
C_C10         0 N1214562  {Cmos_drain}  TC=0,0
X_C41         N1219552 N1219146 CSGP_0805_885012207072_100nF
V_V8         N1216620 N1217102 {Vdriver_out}
R_R8         N1214528 N1214744  {Rmos_pulldown} TC=0,0
R_R51         N1220476 0  {Rmos_pulldown} TC=0,0
C_C29         0 N1216954  {Cmos_drain}  TC=0,0
R_R22         N1216916 N1216902  {Rmos_on} TC=0,0
V_V6         N1215414 0 {Vdriver_out}
R_R31         N1218678 N1218100  {Rmos_ext} TC=0,0
X_C21         N1217102 N1216620 CSGP_2220_885012214006_10uF
X_M7         N1217102 N1218678 0 power_nmos_p PARAMS: BVDSS=100 IDSS=1u
+  VGS_TH=2.7 RDSON=2.6m GFS=59 CISS=6101p COSS=1343p CRSS=46p RG=2.7 VSD=0.85
+  QG=84n V_QG=20 TRR=103n
X_C6         N1214744 N12148300 CSGP_2220_885012214006_10uF
R_R30         N1217102 N12181340  {R_snubber} TC=0,0
V_V3         N1214664 N1215606 {Vdriver_in}
X_D2         N1214522 N1214514 power_diode_p PARAMS: I_REV_LEAK=0.5m
+  CT_ZERO_VOLTS=50p V_BR=40 VJ_KNEE=0.55 VJ_SPEC=0.85 IF_SPEC=1
X_U2         N1222777 N1222789 N1217022 N1218014 0 N1218300 N1216620 N1217356
+  N1217102 N1218074 N1218590 0 UCC21550-Q1
X_M12         N1219552 N12207081 0 power_nmos_p PARAMS: BVDSS=100 IDSS=1u
+  VGS_TH=2.7 RDSON=2.6m GFS=59 CISS=6101p COSS=1343p CRSS=46p RG=2.7 VSD=0.85
+  QG=84n V_QG=20 TRR=103n
X_M1         N1214562 N12147581 N1214744 power_nmos_p PARAMS: BVDSS=100 IDSS=1u
+  VGS_TH=2.7 RDSON=2.6m GFS=59 CISS=6101p COSS=1343p CRSS=46p RG=2.7 VSD=0.85
+  QG=84n V_QG=10 TRR=103n
X_C42         N1219552 N1219146 CSGP_2220_885012214006_10uF
R_R36         N1219294 N1219288  {Rmos_off} TC=0,0
X_C35         0 N1218074 CSGP_1206_885012208089_220nF
L_L2         N1216014 N1215648  0.06465u
R_R29         N1217102 N1218532  {R_snubber} TC=0,0
D_D3         N1214744 N1214528 DI_B0530W
D_D19         N1219552 N1219294 DI_B0530W
V_V13         N1219032 0 {Vdriver_out}
C_C28         0 N1216954  {Cmos_drain}  TC=0,0
X_C17         0 N12156960 CSGP_2220_885012214006_10uF
R_R5         N1214562 N12148300  {R_snubber} TC=0,0
R_R11         N1215662 N1215656  {Rmos_off} TC=0,0
X_C36         0 N1218532 CSGP_2220_885012214006_10uF
R_R41         N12196641 N1219294  {Rmos_ext} TC=0,0
C_C13         0 N1214562  {Cmos_drain}  TC=0,0
R_R12         N1214744 N12156740  {R_snubber} TC=0,0
R_R35         N12190581 N1219032  {Rbootstrap} TC=0,0
X_D4         N1215656 N1215648 power_diode_p PARAMS: I_REV_LEAK=0.5m
+  CT_ZERO_VOLTS=50p V_BR=40 VJ_KNEE=0.55 VJ_SPEC=0.85 IF_SPEC=1
R_R48         N12206781 N1220476  {Rmos_ext} TC=0,0
C_C26         0 N1216954  {Cmos_drain}  TC=0,0
R_R2         N1214528 N1214522  {Rmos_off} TC=0,0
X_C45         N1220404 N1219600 CSGP_0805_885012207078_1uF
V_V4         N1214562 0 {V_bus}
X_C19         0 N1216506 CSGP_0805_885012207098_100nF
R_R9         N1215750 0  {Rdt} TC=0,0
R_R16         N1216140 N1215662  {Rmos_ext} TC=0,0
C_C49         0 N1219436  {Cmos_drain}  TC=0,0
X_C31         0 N1214562 AIG5_861021386031_0R47mF
D_D5         N1214744 N1214528 DI_B0530W
R_R33         N1218722 N1218100  {Rmos_ext} TC=0,0
V_V7         N1216506 0 {Vdriver_out}
R_R10         N1215410 N1215414  1 TC=0,0
V_V9         N1217022 N1218014 {Vdriver_in}
R_R3         N1214562 N12147820  {R_snubber} TC=0,0
C_C51         0 N1219436  {Cmos_drain}  TC=0,0
X_U3         N1222801 N1222822 N1219600 N1220404 0 N1220584 N1219146 N1219874
+  N1219552 N1220212 N1220960 0 UCC21550-Q1
R_R47         N1219552 N12205340  {R_snubber} TC=0,0
C_C48         0 N1219436  {Cmos_drain}  TC=0,0
X_C20         N1217102 N1216620 CSGP_0805_885012207072_100nF
X_C22         N1217102 N12171880 CSGP_2220_885012214006_10uF
R_R18         N12165321 N1216506  {Rbootstrap} TC=0,0
X_M5         N1216954 N1217408 N1217102 power_nmos_p PARAMS: BVDSS=100 IDSS=1u
+  VGS_TH=2.7 RDSON=2.6m GFS=59 CISS=6101p COSS=1343p CRSS=46p RG=2.7 VSD=0.85
+  QG=84n V_QG=20 TRR=103n
L_L3         N1217356 N1216902  0.00967u
R_R37         N1219436 N1219680  {R_snubber} TC=0,0
X_C7         N1215606 N1214664 CSGP_0805_885012207078_1uF
R_R46         N1219552 N12205000  {R_snubber} TC=0,0
V_V14         N1219146 N1219552 {Vdriver_out}
R_R28         N1218100 N1218094  {Rmos_off} TC=0,0
R_R50         N12207081 N1220476  {Rmos_ext} TC=0,0
X_M11         N1219552 N12206781 0 power_nmos_p PARAMS: BVDSS=100 IDSS=1u
+  VGS_TH=2.7 RDSON=2.6m GFS=59 CISS=6101p COSS=1343p CRSS=46p RG=2.7 VSD=0.85
+  QG=84n V_QG=20 TRR=103n
X_C14         N1215414 0 CSGP_1206_885012108022_10uF
X_M10         N1219436 N12196941 N1219552 power_nmos_p PARAMS: BVDSS=100
+  IDSS=1u VGS_TH=2.7 RDSON=2.6m GFS=59 CISS=6101p COSS=1343p CRSS=46p RG=2.7
+  VSD=0.85 QG=84n V_QG=20 TRR=103n
V_V44 N1222748 0 0
V_V45 N1222760 0 0
V_V46 N1222777 0 0
V_V47 N1222789 0 0
V_V49 N1222822 0 0
V_V48 N1222801 0 0
** Floating/unmodeled pin fixups **
R__UC0001   M_UN0001  0   {1/GMIN}
R__UC0002   M_UN0002  0   {1/GMIN}
.ends PSpiceBlock

X_PSpiceBlock dummy PSpiceBlock

.TRAN 0 10.5 SKIPBP
.PROBE64 N([X_PSpiceBlock.N1219552])
.PROBE64 N([X_PSpiceBlock.N1214744])
.PROBE64 N([X_PSpiceBlock.N1218722])
.PROBE64 N([X_PSpiceBlock.N1219552])
.PROBE64 N([X_PSpiceBlock.N1217102])
.PROBE64 N([X_PSpiceBlock.N1214744])

.END
