** Profile: "SCHEMATIC1-motoroldum"  [ C:\Users\ahmet\Desktop\gatedenyiyenler\makinelesmekistiyorum-pspicefiles\schematic1\motoroldum.sim ]

** Creating circuit file "motoroldum.cir"
** WARNING: THIS AUTOMATICALLY GENERATED FILE MAY BE OVERWRITTEN BY SUBSEQUENT SIMULATIONS

*Libraries:
* Profile Libraries :
* Local Libraries :
* From [PSPICE NETLIST] section of C:\Users\ahmet\AppData\Roaming\SPB_Data\cdssetup\OrCAD_PSpice\22.1.0\PSpice.ini file:
.lib "nom.lib"

*Analysis directives:
.TRAN  0 10s 0
.OPTIONS ADVCONV
.OPTIONS RELTOL= 0.01
.PROBE V(alias(*)) I(alias(*)) W(alias(*)) D(alias(*)) NOISE(alias(*))
.INC "..\SCHEMATIC1.net"

.END
