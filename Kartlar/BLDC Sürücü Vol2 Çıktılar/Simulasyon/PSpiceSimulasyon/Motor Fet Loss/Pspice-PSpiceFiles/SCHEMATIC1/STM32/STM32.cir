** Profile: "SCHEMATIC1-STM32"  [ C:\Users\ahmet\Desktop\Motor\pspice-pspicefiles\schematic1\stm32.sim ]

** Creating circuit file "STM32.cir"
** WARNING: THIS AUTOMATICALLY GENERATED FILE MAY BE OVERWRITTEN BY SUBSEQUENT SIMULATIONS

*Libraries:
* Profile Libraries :
* Local Libraries :
.LIB "C:/Users/ahmet/Desktop/pspice lib/mv5_100v_std_rev1p0_pspice.txt"
.LIB "C:/Users/ahmet/Desktop/pspice lib/b0530w.spice.txt"
.LIB "C:/Users/ahmet/Desktop/pspice lib/ucc/ucc21550-q1.lib"
.LIB "C:/Users/ahmet/Desktop/pspice lib/wcap-atul.lib"
.LIB "C:/Users/ahmet/Desktop/pspice lib/ss14.lib"
* From [PSPICE NETLIST] section of C:\Users\ahmet\AppData\Roaming\SPB_Data\cdssetup\OrCAD_PSpice\17.4.0\PSpice.ini file:
.lib "nom.lib"

*Analysis directives:
.TRAN  0 2000u 0 1e-6
.OPTIONS ADVCONV
.OPTIONS ABSTOL= 1e-12
.OPTIONS VNTOL= 1e-06
.AUTOCONVERGE ITL1=150 ITL2=20 ITL4=100 RELTOL=0.05 ABSTOL=1.0E-6 VNTOL=.001 PIVTOL=1.0E-10
.PROBE64 V(alias(*)) I(alias(*)) W(alias(*)) D(alias(*)) NOISE(alias(*))
.INC "..\SCHEMATIC1.net"

.END
