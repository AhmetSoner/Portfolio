** Profile: "SCHEMATIC1-withoutmosfet"  [ C:\Cadence\SPB_17.4\tools\pspice\capture_samples\CoSimulationDemos\PSpiceCoSim\Motor\Pspice-PSpiceFiles\SCHEMATIC1\withoutmosfet.sim ]

** Creating circuit file "withoutmosfet.cir"
** WARNING: THIS AUTOMATICALLY GENERATED FILE MAY BE OVERWRITTEN BY SUBSEQUENT SIMULATIONS

*Libraries:
* Profile Libraries :
* Local Libraries :
.LIB "C:/Users/ahmet/Desktop/PSPice Lib/MV5_100V_STD_rev1p0_pspice.txt"
.LIB "C:/Users/ahmet/Desktop/PSPice Lib/B0530W.spice.txt"
.LIB "C:/Users/ahmet/Desktop/PSPice Lib/UCC/ucc21550-q1.lib"
.LIB "C:/Users/ahmet/Desktop/PSPice Lib/WCAP-ATUL.lib"
.LIB "C:/Users/ahmet/Desktop/PSPice Lib/ss14.lib"
* From [PSPICE NETLIST] section of C:\Users\ahmet\AppData\Roaming\SPB_Data\cdssetup\OrCAD_PSpice\17.4.0\PSpice.ini file:
.lib "nom.lib"

*Analysis directives:
.TRAN  0 60000u 0 1e-6
.OPTIONS ADVCONV
.OPTIONS ABSTOL= 1e-12
.OPTIONS VNTOL= 1e-06
.AUTOCONVERGE ITL1=150 ITL2=20 ITL4=100 RELTOL=0.05 ABSTOL=1.0E-6 VNTOL=.001 PIVTOL=1.0E-10
.PROBE64 V(alias(*)) I(alias(*)) W(alias(*)) D(alias(*)) NOISE(alias(*))
.INC "..\SCHEMATIC1.net"

.END
