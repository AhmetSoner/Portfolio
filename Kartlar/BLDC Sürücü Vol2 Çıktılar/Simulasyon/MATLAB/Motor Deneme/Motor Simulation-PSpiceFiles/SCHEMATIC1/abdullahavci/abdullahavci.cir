** Profile: "SCHEMATIC1-abdullahavci"  [ c:\users\ahmet\desktop\motor simulation\motor simulation-pspicefiles\schematic1\abdullahavci.sim ]

** Creating circuit file "abdullahavci.cir"
** WARNING: THIS AUTOMATICALLY GENERATED FILE MAY BE OVERWRITTEN BY SUBSEQUENT SIMULATIONS

*Libraries:
* Profile Libraries :
* Local Libraries :
.LIB "c:/users/ahmet/desktop/pspice/ucc21550-q1.lib"
.LIB "C:/Cadence/PSpiceTI/tools/capture/library/pspice/WCAP-CSGP_25V.lib"
.LIB "C:/Cadence/PSpiceTI/tools/capture/library/pspice/siemens.lib.txt"
.LIB "c:/users/ahmet/desktop/pspice lib/aluminium cap/wcap-aig5.lib"
.LIB "c:/users/ahmet/desktop/pspice lib/wcap-atg5.lib"
.LIB "c:/users/ahmet/desktop/pspice lib/we-csgp_simple_models/wcap-csgp_50v.lib"
.LIB "c:/users/ahmet/desktop/pspice lib/we-csgp_simple_models/wcap-csgp_100v.lib"
.LIB "C:/Cadence/PSpiceTI/tools/capture/library/pspice/mix_misc.lib.txt"
* From [PSPICE NETLIST] section of C:\cds_spb_home\cdssetup\OrCAD_PSpiceTIPSpice_Install\23.1.0\PSpice.ini file:
.lib "nom.lib"
.lib "nom_pspti.lib"

*Analysis directives:
.TRAN  0 1000us 0
.OPTIONS ADVCONV
.OPTIONS FILEMODELSEARCH
.PROBE64 V(alias(*)) I(alias(*)) W(alias(*)) D(alias(*)) NOISE(alias(*))
.INC "..\SCHEMATIC1.net"

.END
