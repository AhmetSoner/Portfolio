** Profile: "SCHEMATIC1-Clamp deneyecem"  [ c:\users\ahmet\desktop\motor simulation\motor simulation-pspicefiles\schematic1\clamp deneyecem.sim ]

** Creating circuit file "Clamp deneyecem.cir"
** WARNING: THIS AUTOMATICALLY GENERATED FILE MAY BE OVERWRITTEN BY SUBSEQUENT SIMULATIONS

*Libraries:
* Profile Libraries :
* Local Libraries :
.LIB "C:/Cadence/PSpiceTI/tools/capture/library/pspice/WCAP-CSGP_25V.lib"
.LIB "C:/Cadence/PSpiceTI/tools/capture/library/pspice/zetex.lib.txt"
.LIB "C:/Cadence/PSpiceTI/tools/capture/library/pspice/siemens.lib.txt"
.LIB "c:/users/ahmet/desktop/pspice lib/phil_fet.olb/phil_fet.lib.txt"
.LIB "c:/users/ahmet/desktop/pspice lib/aluminium cap/wcap-aig5.lib"
.LIB "c:/users/ahmet/desktop/pspice lib/wcap-atg5.lib"
.LIB "c:/users/ahmet/desktop/pspice lib/we-csgp_simple_models/wcap-csgp_50v.lib"
.LIB "c:/users/ahmet/desktop/pspice lib/we-csgp_simple_models/wcap-csgp_100v.lib"
.LIB "C:/Cadence/PSpiceTI/tools/capture/library/pspice/mix_misc.lib.txt"
* From [PSPICE NETLIST] section of C:\Users\ahmet\AppData\Roaming\SPB_Data\cdssetup\OrCAD_PSpice\22.1.0\PSpice.ini file:
.lib "nom.lib"

*Analysis directives:
.TRAN  0 1000us 0
.OPTIONS STEPGMIN
.OPTIONS ADVCONV
.AUTOCONVERGE ITL1=1000 ITL2=1000 ITL4=1000 RELTOL=0.05 ABSTOL=1.0E-6 VNTOL=.001 PIVTOL=1.0E-10
.PROBE64 V(alias(*)) I(alias(*)) W(alias(*)) D(alias(*)) NOISE(alias(*))
.INC "..\SCHEMATIC1.net"

.END
