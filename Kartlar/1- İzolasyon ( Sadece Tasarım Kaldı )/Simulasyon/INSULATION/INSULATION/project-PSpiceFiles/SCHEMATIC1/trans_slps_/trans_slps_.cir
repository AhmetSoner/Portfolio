** Profile: "SCHEMATIC1-trans"  [ C:\Cadence\SPB_17.4\tools\pspice\capture_samples\CoSimulationDemos\PSpiceCoSim\INSULATION\project-PSpiceFiles\SCHEMATIC1\trans.sim ]

** Creating circuit file "trans.cir"
** WARNING: THIS AUTOMATICALLY GENERATED FILE MAY BE OVERWRITTEN BY SUBSEQUENT SIMULATIONS

*Libraries:
* Profile Libraries :
* Local Libraries :
* From [PSPICE NETLIST] section of C:\Users\ahmet\AppData\Roaming\SPB_Data\cdssetup\OrCAD_PSpice/17.4.0/PSpice.ini file:
.lib "C:\Cadence\SPB_17.4\tools\pspice\library\LP2985-33.LIB"
.lib "C:\Cadence\SPB_17.4\tools\pspice\library\AMC3330.lib"
.lib "C:\Cadence\SPB_17.4\tools\pspice\library\tlv6001.lib"
.lib "nom.lib"

*Analysis directives:
.TRAN  0 5000u 0 1e-6
.OPTIONS ADVCONV
.OPTIONS CHGTOL= 0.1p
.AUTOCONVERGE ITL1=1000 ITL2=1000 ITL4=1000 RELTOL=0.05 ABSTOL=1.0E-6 VNTOL=.001 PIVTOL=1.0E-10
.PROBE64 V(alias(*)) I(alias(*)) W(alias(*)) D(alias(*)) NOISE(alias(*))
.INC "..\SCHEMATIC1.net"

.END
